| / 7\'7
| \ \   Xilinx Inc.
| / /
| \_\/.\   IBIS Models for VIRTEX-5
[IBIS ver]   3.2
[File name]   cru.ibs
[File Rev]   2.6
[Date]   Thu Feb 24 11:15:33 2011
[Source]   Derived from spice models, rev0.20, dated 08/17/2007 using
   hspice 2005.03
[Notes]   Xilinx IBIS file for VIRTEX-5 I/O standards.
   All models are preliminary.
   The version of IBISCHK used is ibischk4.
   Ibis models were generated using S2IBIS3.
[Disclaimer] The data in this file is derived from SPICE simulations using
                 modeling information extracted from the target process. While
                 a great deal of care has been taken to provide information
                 that is accurate, this model is considered preliminary as it
                 has not been verified by actual silicon measurement. Treat the
                 data in this model as preliminary until actual silicon
                 verification is performed.
[Copyright]   Copyright 2007, Xilinx Inc., All rights reserved
|   Component VIRTEX-5
[Component]   VIRTEX-5
[Manufacturer]   Xilinx Inc.
[Package]
|FF1136
|variable   typ   min   max
R_pkg   329.46m   22.22m   1036.83m
L_pkg   3.71nH   0.52nH   10.16nH
C_pkg   2.22pF   0.93pF   5.00pF
[Pin]  signal_name   model_name   R_pin   L_pin   C_pin
H17   fpga_100m_clk   LVCMOS25_S_2
AK6   clk100m_ctu_out_b   LVDS_25
H20   clk100m_ctu_b   LVDS_25
J12   mrst_b   LVCMOS25_S_12
G22   REFCLK_125MHz   LVCMOS25_S_12
V10   clk100m_ctu_out_test LVDS_25
H12   UDPRst_200_b   LVCMOS25_S_12
AK7   clk100m_ctu_out   LVDS_25
H19   clk100m_ctu   LVDS_25
K12   UDPRst_125_b   LVCMOS25_S_12
R34   cru_reset   LVCMOS25_S_2
K21   up_clk   LVCMOS25_S_12
H13   using_ext_clock_led  LVCMOS25_S_12
AN34   fpga_cpu_reset   LVCMOS25_S_2
L21   mclk   LVCMOS25_S_12
J15   REFCLK_200MHz   LVCMOS25_S_12
V9   clk100m_ctu_out_b_test LVDS_25
K14   up_rst_b   LVCMOS25_S_12
L16   fe_clk   LVCMOS25_S_12
K22   fe_rst_b   LVCMOS25_S_12
U18   VP_0   NC
V17   VN_0   NC
L20   A18   LVCMOS25_F_12
L15   A17   LVCMOS25_F_12
J22   A15_D31   NC
K16   A13_D29   NC
H22   A10_D26   NC
L14   A9_D25   NC
K23   A7_D23   NC
G23   A3_D19   NC
H23   A2_D18   NC
K13   A1_D17   NC
AE13   RS1   LVCMOS25_F_12
AE12   RS0   LVCMOS25_F_12
AF23   A25   LVCMOS25_F_12
AG23   A24   LVCMOS25_F_12
AF13   A23   LVCMOS25_F_12
AG12   A22   LVCMOS25_F_12
AE22   A21   LVCMOS25_F_12
AE23   A20   LVCMOS25_F_12
AE14   FCS_B   LVCMOS25_F_12
AF14   FOE_B_MOSI   NC
AF20   FWE_B   LVCMOS25_F_12
AF21   CSO_B   LVCMOS25_F_12
AF15   D7   LVCMOS25_F_12
AE16   D6   LVCMOS25_F_12
AE21   D5   LVCMOS25_F_12
AD20   D4   LVCMOS25_F_12
AF16   D3   LVCMOS25_F_12
AE17   D2_FS2   NC
AE19   D1_FS1   NC
AD19   D0_FS0   NC
H18   IO_L0N_CC_GC_3   NC
K17   IO_L1P_CC_GC_3   NC
L18   IO_L1N_CC_GC_3   NC
G15   IO_L2P_GC_VRN_3   NC
G16   IO_L2N_GC_VRP_3   NC
K18   IO_L3P_GC_3   NC
J19   IO_L3N_GC_3   NC
J16   IO_L4P_GC_3   NC
J17   IO_L4N_GC_VREF_3   NC
L19   IO_L5P_GC_3   NC
K19   IO_L5N_GC_3   NC
H14   IO_L6P_GC_3   NC
H15   IO_L6N_GC_3   NC
J20   IO_L7P_GC_3   NC
J21   IO_L7N_GC_3   NC
J14   IO_L8P_GC_3   NC
AG22   D15   LVCMOS25_F_12
AH22   D14   LVCMOS25_F_12
AH12   D13   LVCMOS25_F_12
AG13   D12   LVCMOS25_F_12
AH20   D11   LVCMOS25_F_12
AH19   D10   LVCMOS25_F_12
AH14   D9   LVCMOS25_F_12
AH13   D8   LVCMOS25_F_12
AG21   IO_L4P_GC_4   NC
AG20   IO_L4N_GC_VREF_4   NC
AH15   IO_L5P_GC_4   NC
AG15   IO_L5N_GC_4   NC
AG18   IO_L6P_GC_4   NC
AF19   IO_L6N_GC_4   NC
AH17   IO_L7P_GC_VRN_4   NC
AG16   IO_L7N_GC_VRP_4   NC
AF18   IO_L8P_CC_GC_4   NC
AE18   IO_L8N_CC_GC_4   NC
AH18   IO_L9P_CC_GC_4   NC
AG17   IO_L9N_CC_GC_4   NC
B32   IO_L0P_11   NC
A33   IO_L0N_11   NC
B33   IO_L1P_11   NC
C33   IO_L1N_11   NC
C32   IO_L2P_11   NC
D32   IO_L2N_11   NC
C34   IO_L3P_11   NC
D34   IO_L3N_11   NC
G32   IO_L4P_11   NC
H32   IO_L4N_VREF_11   NC
F33   IO_L5P_11   NC
E34   IO_L5N_11   NC
E32   IO_L6P_11   NC
E33   IO_L6N_11   NC
G33   IO_L7P_11   NC
F34   IO_L7N_11   NC
J32   IO_L8P_CC_11   NC
H33   IO_L8N_CC_11   NC
H34   IO_L9P_CC_11   NC
J34   IO_L9N_CC_11   NC
L34   SM15P   NC
K34   SM15N   NC
K33   SM14P   NC
K32   SM14N   NC
N33   IO_L12P_VRN_11   NC
M33   IO_L12N_VRP_11   NC
L33   IO_L13P_11   NC
M32   IO_L13N_11   NC
P34   IO_L14P_11   NC
N34   IO_L14N_VREF_11   NC
P32   SM13P   NC
N32   SM13N   NC
T33   SM12P   NC
R33   SM11P   NC
R32   SM11N   NC
U33   SM10P   NC
T34   SM10N   NC
U32   SM9P   NC
U31   SM9N   NC
M6   IO_L0P_12   NC
M5   IO_L0N_12   NC
N8   IO_L1P_12   NC
N7   IO_L1N_12   NC
M7   IO_L2P_12   NC
L6   IO_L2N_12   NC
N5   IO_L3P_12   NC
P5   IO_L3N_12   NC
L4   IO_L4P_12   NC
L5   IO_L4N_VREF_12   NC
P7   IO_L5P_12   NC
P6   IO_L5N_12   NC
K7   IO_L6P_12   NC
K6   IO_L6N_12   NC
R6   IO_L7P_12   NC
T6   IO_L7N_12   NC
J6   IO_L8P_CC_12   NC
J5   IO_L8N_CC_12   NC
R7   IO_L9P_CC_12   NC
R8   IO_L9N_CC_12   NC
T8   IO_L10P_CC_12   NC
U7   IO_L10N_CC_12   NC
H7   IO_L11P_CC_12   NC
J7   IO_L11N_CC_12   NC
R9   IO_L12P_VRN_12   NC
P9   IO_L12N_VRP_12   NC
H5   IO_L13P_12   NC
G5   IO_L13N_12   NC
R11   IO_L14P_12   NC
P10   IO_L14N_VREF_12   NC
F5   IO_L15P_12   NC
F6   IO_L15N_12   NC
T10   IO_L16P_12   NC
T11   IO_L16N_12   NC
G6   IO_L17P_12   NC
G7   IO_L17N_12   NC
T9   IO_L18P_12   NC
U10   IO_L18N_12   NC
E6   IO_L19P_12   NC
E7   IO_L19N_12   NC
V32   SM8P   NC
V33   SM8N   NC
W34   SM7P   NC
V34   SM7N   NC
Y33   SM6P   NC
AA33   SM6N   NC
AA34   SM5P   NC
Y34   SM5N   NC
Y32   IO_L4P_13   NC
W32   IO_L4N_VREF_13   NC
AC34   SM4P   NC
AD34   SM4N   NC
AC32   SM3P   NC
AB32   SM3N   NC
AC33   SM2P   NC
AB33   SM2N   NC
AF33   SM1P   NC
AE33   SM1N   NC
AF34   SM0P   NC
AE34   SM0N   NC
AH34   IO_L10P_CC_13   NC
AJ34   IO_L10N_CC_13   NC
AD32   IO_L11P_CC_13   NC
AE32   IO_L11N_CC_13   NC
AG33   IO_L12P_VRN_13   NC
AH33   IO_L12N_VRP_13   NC
AK34   IO_L13P_13   NC
AK33   IO_L13N_13   NC
AG32   IO_L14P_13   NC
AH32   IO_L14N_VREF_13   NC
AJ32   IO_L15P_13   NC
AK32   IO_L15N_13   NC
AL34   IO_L16P_13   NC
AL33   IO_L16N_13   NC
AM33   IO_L17P_13   NC
AM32   IO_L17N_13   NC
AN33   IO_L18N_13   NC
AN32   IO_L19P_13   NC
AP32   IO_L19N_13   NC
E29   IO_L0P_15   NC
F29   IO_L0N_15   NC
G30   IO_L1P_15   NC
F30   IO_L1N_15   NC
H29   IO_L2P_15   NC
J29   IO_L2N_15   NC
F31   IO_L3P_15   NC
E31   IO_L3N_15   NC
L29   IO_L4P_15   NC
K29   IO_L4N_VREF_15   NC
H30   IO_L5P_15   NC
G31   IO_L5N_15   NC
J30   IO_L6P_15   NC
J31   IO_L6N_15   NC
L30   IO_L7P_15   NC
M30   IO_L7N_15   NC
N29   IO_L8P_CC_15   NC
P29   IO_L8N_CC_15   NC
K31   IO_L9P_CC_15   NC
L31   IO_L9N_CC_15   NC
P31   IO_L10P_CC_15   NC
P30   IO_L10N_CC_15   NC
M31   IO_L11P_CC_15   NC
N30   IO_L11N_CC_15   NC
R28   IO_L12P_VRN_15   NC
R29   IO_L12N_VRP_15   NC
T31   IO_L13P_15   NC
R31   IO_L13N_15   NC
U30   IO_L14P_15   NC
T30   IO_L14N_VREF_15   NC
T28   IO_L15P_15   NC
T29   IO_L15N_15   NC
U27   IO_L16P_15   NC
U28   IO_L16N_15   NC
R26   IO_L17P_15   NC
R27   IO_L17N_15   NC
U26   IO_L18P_15   NC
T26   IO_L18N_15   NC
U25   IO_L19P_15   NC
T25   IO_L19N_15   NC
W24   IO_L0P_17   NC
V24   IO_L0N_17   NC
Y26   IO_L1P_17   NC
W26   IO_L1N_17   NC
V25   IO_L2P_17   NC
W25   IO_L2N_17   NC
Y27   IO_L3P_17   NC
W27   IO_L3N_17   NC
V30   IO_L4P_17   NC
W30   IO_L4N_VREF_17   NC
V28   IO_L5P_17   NC
V27   IO_L5N_17   NC
W31   IO_L6P_17   NC
Y31   IO_L6N_17   NC
W29   IO_L7P_17   NC
V29   IO_L7N_17   NC
Y28   IO_L8P_CC_17   NC
Y29   IO_L8N_CC_17   NC
AB31   IO_L9P_CC_17   NC
AA31   IO_L9N_CC_17   NC
AB30   IO_L10P_CC_17   NC
AC30   IO_L10N_CC_17   NC
AA29   IO_L11P_CC_17   NC
AA30   IO_L11N_CC_17   NC
AD31   IO_L12P_VRN_17   NC
AE31   IO_L12N_VRP_17   NC
AD30   IO_L13P_17   NC
AC29   IO_L13N_17   NC
AF31   IO_L14P_17   NC
AG31   IO_L14N_VREF_17   NC
AE29   IO_L15P_17   NC
AD29   IO_L15N_17   NC
AJ31   IO_L16P_17   NC
AK31   IO_L16N_17   NC
AF29   IO_L17P_17   NC
AF30   IO_L17N_17   NC
AJ30   IO_L18P_17   NC
AH30   IO_L18N_17   NC
AH29   IO_L19P_17   NC
AG30   IO_L19N_17   NC
AC4   IO_L0P_18   NC
AC5   IO_L0N_18   NC
AB6   IO_L1P_18   NC
AB7   IO_L1N_18   NC
AA5   IO_L2P_18   NC
AB5   IO_L2N_18   NC
AC7   IO_L3P_18   NC
AD7   IO_L3N_18   NC
Y8   IO_L4P_18   NC
Y9   IO_L4N_VREF_18   NC
AD4   IO_L5P_18   NC
AD5   IO_L5N_18   NC
AA6   IO_L6P_18   NC
Y7   IO_L6N_18   NC
AD6   IO_L7P_18   NC
AE6   IO_L7N_18   NC
W6   IO_L8P_CC_18   NC
Y6   IO_L8N_CC_18   NC
AE7   IO_L9P_CC_18   NC
AF6   IO_L9N_CC_18   NC
AG5   IO_L10P_CC_18   NC
AF5   IO_L10N_CC_18   NC
W7   IO_L11P_CC_18   NC
V7   IO_L11N_CC_18   NC
AH5   IO_L12P_VRN_18   NC
AG6   IO_L12N_VRP_18   NC
Y11   IO_L13P_18   NC
W11   IO_L13N_18   NC
AH7   IO_L14P_18   NC
AG7   IO_L14N_VREF_18   NC
W10   IO_L15P_18   NC
W9   IO_L15N_18   NC
AJ7   IO_L16P_18   NC
AJ6   IO_L16N_18   NC
V8   IO_L17P_18   NC
U8   IO_L17N_18   NC
K24   IO_L0P_19   NC
L24   IO_L0N_19   NC
L25   IO_L1P_19   NC
L26   IO_L1N_19   NC
J24   IO_L2P_19   NC
J25   IO_L2N_19   NC
M25   IO_L3P_19   NC
M26   IO_L3N_19   NC
J27   IO_L4P_19   NC
J26   IO_L4N_VREF_19   NC
G25   IO_L5P_19   NC
G26   IO_L5N_19   NC
H25   IO_L6P_19   NC
H24   IO_L6N_19   NC
F25   IO_L7P_19   NC
F26   IO_L7N_19   NC
G27   IO_L8P_CC_19   NC
H27   IO_L8N_CC_19   NC
H28   IO_L9P_CC_19   NC
G28   IO_L9N_CC_19   NC
E28   IO_L10P_CC_19   NC
F28   IO_L10N_CC_19   NC
E26   IO_L11P_CC_19   NC
E27   IO_L11N_CC_19   NC
N27   IO_L12P_VRN_19   NC
M27   IO_L12N_VRP_19   NC
K28   IO_L13P_19   NC
L28   IO_L13N_19   NC
K27   IO_L14P_19   NC
K26   IO_L14N_VREF_19   NC
M28   IO_L15P_19   NC
N28   IO_L15N_19   NC
P26   IO_L16P_19   NC
P27   IO_L16N_19   NC
N24   IO_L17P_19   NC
P24   IO_L17N_19   NC
P25   IO_L18P_19   NC
N25   IO_L18N_19   NC
R24   IO_L19P_19   NC
T24   IO_L19N_19   NC
E9   IO_L0P_20   NC
E8   IO_L0N_20   NC
F9   IO_L1P_20   NC
F8   IO_L1N_20   NC
F10   IO_L2P_20   NC
G10   IO_L2N_20   NC
G8   IO_L3P_20   NC
H8   IO_L3N_20   NC
D11   IO_L4P_20   NC
D10   IO_L4N_VREF_20   NC
K11   IO_L5P_20   NC
J11   IO_L5N_20   NC
D12   IO_L6P_20   NC
C12   IO_L6N_20   NC
H10   IO_L7P_20   NC
H9   IO_L7N_20   NC
A13   IO_L8P_CC_20   NC
B12   IO_L8N_CC_20   NC
J10   IO_L9P_CC_20   NC
J9   IO_L9N_CC_20   NC
K8   IO_L10P_CC_20   NC
K9   IO_L10N_CC_20   NC
B13   IO_L11P_CC_20   NC
C13   IO_L11N_CC_20   NC
L10   IO_L12P_VRN_20   NC
L11   IO_L12N_VRP_20   NC
G11   IO_L13P_20   NC
G12   IO_L13N_20   NC
M8   IO_L14P_20   NC
L8   IO_L14N_VREF_20   NC
F11   IO_L15P_20   NC
E11   IO_L15N_20   NC
M10   IO_L16P_20   NC
L9   IO_L16N_20   NC
E12   IO_L17P_20   NC
E13   IO_L17N_20   NC
N10   IO_L18P_20   NC
N9   IO_L18N_20   NC
F13   IO_L19P_20   NC
G13   IO_L19N_20   NC
AA25   IO_L0P_21   NC
AA26   IO_L0N_21   NC
AB27   IO_L1P_21   NC
AC27   IO_L1N_21   NC
Y24   IO_L2P_21   NC
AA24   IO_L2N_21   NC
AB25   IO_L3P_21   NC
AB26   IO_L3N_21   NC
AC28   IO_L4P_21   NC
AD27   IO_L4N_VREF_21   NC
AB28   IO_L5P_21   NC
AA28   IO_L5N_21   NC
AG28   IO_L6P_21   NC
AH28   IO_L6N_21   NC
AE28   IO_L7P_21   NC
AF28   IO_L7N_21   NC
AK26   IO_L8P_CC_21   NC
AJ27   IO_L8N_CC_21   NC
AK29   IO_L9P_CC_21   NC
AJ29   IO_L9N_CC_21   NC
AK28   IO_L10P_CC_21   NC
AK27   IO_L10N_CC_21   NC
AH27   IO_L11P_CC_21   NC
AJ26   IO_L11N_CC_21   NC
AJ25   IO_L12P_VRN_21   NC
AH25   IO_L12N_VRP_21   NC
AF24   IO_L13P_21   NC
AG25   IO_L13N_21   NC
AG27   IO_L14P_21   NC
AG26   IO_L14N_VREF_21   NC
AF25   IO_L15P_21   NC
AF26   IO_L15N_21   NC
AE27   IO_L16P_21   NC
AE26   IO_L16N_21   NC
AC25   IO_L17P_21   NC
AC24   IO_L17N_21   NC
AD26   IO_L18P_21   NC
AD25   IO_L18N_21   NC
AD24   IO_L19P_21   NC
AE24   IO_L19N_21   NC
AN14   IO_L0P_22   NC
AP14   IO_L0N_22   NC
AB10   IO_L1P_22   NC
AA10   IO_L1N_22   NC
AN13   IO_L2P_22   NC
AM13   IO_L2N_22   NC
AA8   IO_L3P_22   NC
AA9   IO_L3N_22   NC
AP12   IO_L4P_22   NC
AN12   IO_L4N_VREF_22   NC
AC8   IO_L5P_22   NC
AB8   IO_L5N_22   NC
AM12   IO_L6P_22   NC
AM11   IO_L6N_22   NC
AC10   IO_L7P_22   NC
AC9   IO_L7N_22   NC
AL11   IO_L8P_CC_22   NC
AL10   IO_L8N_CC_22   NC
AE8   IO_L9P_CC_22   NC
AD9   IO_L9N_CC_22   NC
AD10   IO_L10P_CC_22   NC
AD11   IO_L10N_CC_22   NC
AK11   IO_L11P_CC_22   NC
AJ11   IO_L11N_CC_22   NC
AF8   IO_L12P_VRN_22   NC
AE9   IO_L12N_VRP_22   NC
AK8   IO_L13P_22   NC
AK9   IO_L13N_22   NC
AF9   IO_L14P_22   NC
AF10   IO_L14N_VREF_22   NC
AJ9   IO_L15P_22   NC
AJ10   IO_L15N_22   NC
AF11   IO_L16P_22   NC
AE11   IO_L16N_22   NC
AH9   IO_L17P_22   NC
AH10   IO_L17N_22   NC
AG8   IO_L18P_22   NC
AH8   IO_L18N_22   NC
AG10   IO_L19P_22   NC
AG11   IO_L19N_22   NC
M2   MGTTXP0_112   NC
N2   MGTTXN0_112   NC
N1   MGTRXP0_112   NC
P1   MGTRXN0_112   NC
R1   MGTRXN1_112   NC
P3   MGTREFCLKN_112   NC
T1   MGTRXP1_112   NC
P4   MGTREFCLKP_112   NC
T2   MGTTXN1_112   NC
U2   MGTTXP1_112   NC
V2   MGTTXP0_114   NC
W2   MGTTXN0_114   NC
W1   MGTRXP0_114   NC
Y1   MGTRXN0_114   NC
AA1   MGTRXN1_114   NC
Y3   MGTREFCLKN_114   NC
AB1   MGTRXP1_114   NC
Y4   MGTREFCLKP_114   NC
AB2   MGTTXN1_114   NC
AC2   MGTTXP1_114   NC
F2   MGTTXP0_116   NC
G2   MGTTXN0_116   NC
G1   MGTRXP0_116   NC
H1   MGTRXN0_116   NC
J1   MGTRXN1_116   NC
H3   MGTREFCLKN_116   NC
K1   MGTRXP1_116   NC
H4   MGTREFCLKP_116   NC
K2   MGTTXN1_116   NC
L2   MGTTXP1_116   NC
AD2   MGTTXP0_118   NC
AE2   MGTTXN0_118   NC
AE1   MGTRXP0_118   NC
AF1   MGTRXN0_118   NC
AG1   MGTRXN1_118   NC
AF3   MGTREFCLKN_118   NC
AH1   MGTRXP1_118   NC
AF4   MGTREFCLKP_118   NC
AH2   MGTTXN1_118   NC
AJ2   MGTTXP1_118   NC
B4   MGTTXP0_120   NC
B3   MGTTXN0_120   NC
A3   MGTRXP0_120   NC
A2   MGTRXN0_120   NC
C1   MGTRXN1_120   NC
D4   MGTREFCLKN_120   NC
D1   MGTRXP1_120   NC
E4   MGTREFCLKP_120   NC
D2   MGTTXN1_120   NC
E2   MGTTXP1_120   NC
AK2   MGTTXP0_122   NC
AL2   MGTTXN0_122   NC
AL1   MGTRXP0_122   NC
AM1   MGTRXN0_122   NC
AP2   MGTRXN1_122   NC
AL4   MGTREFCLKN_122   NC
AP3   MGTRXP1_122   NC
AL5   MGTREFCLKP_122   NC
AN3   MGTTXN1_122   NC
AN4   MGTTXP1_122   NC
W18   DXP_0   NC
W17   DXN_0   NC
T18   AVDD_0   NC
T17   AVSS_0   NC
V18   VREFP_0   NC
U17   VREFN_0   NC
L23   VBATT_0   NC
M22   PROGRAM_B_0   NC
M23   HSWAPEN_0   NC
P15   D_IN_0   NC
M15   DONE_0   NC
N15   CCLK_0   NC
N14   INIT_B_0   NC
N22   CS_B_0   NC
N23   RDWR_B_0   NC
AB23   RSVD_0   NC
AC23   RSVD_0   NC
AB15   TCK_0   NC
AD21   M0_0   NC
AD22   M2_0   NC
AC22   M1_0   NC
AC14   TMS_0   NC
AC15   TDI_0   NC
AD15   D_OUT_BUSY_0   NC
AD14   TDO_0   NC
M3   MGTAVTTTX_112   NC
U3   MGTAVTTTX_112   NC
N3   MGTAVTTRX_112   NC
T3   MGTAVCCPLL_112   NC
V5   MGTAVTTRXC   NC
V4   MGTRREF_112   NC
AC3   MGTAVTTTX_114   NC
V3   MGTAVTTTX_114   NC
W3   MGTAVTTRX_114   NC
AB3   MGTAVCCPLL_114   NC
F3   MGTAVTTTX_116   NC
L3   MGTAVTTTX_116   NC
G3   MGTAVTTRX_116   NC
K3   MGTAVCCPLL_116   NC
AD3   MGTAVTTTX_118   NC
AJ3   MGTAVTTTX_118   NC
AE3   MGTAVTTRX_118   NC
AH3   MGTAVCCPLL_118   NC
C4   MGTAVTTTX_120   NC
E3   MGTAVTTTX_120   NC
C3   MGTAVTTRX_120   NC
D3   MGTAVCCPLL_120   NC
AK3   MGTAVTTTX_122   NC
AM3   MGTAVTTTX_122   NC
AL3   MGTAVTTRX_122   NC
AM4   MGTAVCCPLL_122   NC
B1   GND   GND
AN1   GND   GND
B2   GND   GND
C2   GND   GND
H2   GND   GND
J2   GND   GND
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[Diff Pin]   inv_pin   vdiff   tdelay_typ   tdelay_min   tdelay_max
| Models and submodels in the file (4): LVCMOS25_S_2 (I/O), LVCMOS25_F_12 (I/O), LVCMOS25_S_12 (I/O), LVDS_25 (I/O)
